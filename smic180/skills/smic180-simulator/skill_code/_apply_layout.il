let((cv term pin fig bb w h lbl shapes)
  cv = dbOpenCellViewByType("LLM_Layout_Design_Lab" "IO_RING_12x12" "symbol" "schematicSymbol" "a")
  unless(cv error("APPLY-LAYOUT: cannot open cellview"))
  shapes = setof(s cv~>shapes s~>objType == "rect" &&
    ((s~>layerName == "instance" && s~>purpose == "drawing") ||
     (s~>layerName == "device"   && s~>purpose == "drawing")))
  foreach(s shapes dbDeleteObject(s))
  shapes = setof(s cv~>shapes
    s~>objType == "line" && s~>layerName == "device" && s~>purpose == "drawing")
  foreach(s shapes dbDeleteObject(s))
  dbCreateRect(cv list("device" "drawing") list(list(-2.25 -5.25) list(7.25 4.25)))
  dbCreateRect(cv list("device" "drawing") list(list(-1 -4) list(6 3)))
  term = nth(12 cv~>terminals)
  when(term
    pin = nth(0 term~>pins)
    fig = car(pin~>figs)
    bb = fig~>bBox
    w = car(cadr(bb)) - car(car(bb))
    h = cadr(cadr(bb)) - cadr(car(bb))
    fig~>bBox = list(list(-2.625 - w/2.0 2.25 - h/2.0) list(-2.625 + w/2.0 2.25 + h/2.0))
  )
  dbCreateLine(cv list("device" "drawing") list(list(-2.25 2.25) list(-2.625 2.25)))
  lbl = car(setof(s cv~>shapes s~>objType == "label" && s~>theLabel == "DCLK" && abs(car(s~>xy) - 0.2875) < 0.01 && abs(cadr(s~>xy) - 0) < 0.01))
  when(lbl lbl~>xy = list(-2.125 2.25))
  term = nth(10 cv~>terminals)
  when(term
    pin = nth(0 term~>pins)
    fig = car(pin~>figs)
    bb = fig~>bBox
    w = car(cadr(bb)) - car(car(bb))
    h = cadr(cadr(bb)) - cadr(car(bb))
    fig~>bBox = list(list(-2.625 - w/2.0 1.75 - h/2.0) list(-2.625 + w/2.0 1.75 + h/2.0))
  )
  dbCreateLine(cv list("device" "drawing") list(list(-2.25 1.75) list(-2.625 1.75)))
  lbl = car(setof(s cv~>shapes s~>objType == "label" && s~>theLabel == "SYNC" && abs(car(s~>xy) - 0.2875) < 0.01 && abs(cadr(s~>xy) - -0.25) < 0.01))
  when(lbl lbl~>xy = list(-2.125 1.75))
  term = nth(9 cv~>terminals)
  when(term
    pin = nth(0 term~>pins)
    fig = car(pin~>figs)
    bb = fig~>bBox
    w = car(cadr(bb)) - car(car(bb))
    h = cadr(cadr(bb)) - cadr(car(bb))
    fig~>bBox = list(list(-2.625 - w/2.0 1.25 - h/2.0) list(-2.625 + w/2.0 1.25 + h/2.0))
  )
  dbCreateLine(cv list("device" "drawing") list(list(-2.25 1.25) list(-2.625 1.25)))
  lbl = car(setof(s cv~>shapes s~>objType == "label" && s~>theLabel == "VIOH" && abs(car(s~>xy) - 0.2875) < 0.01 && abs(cadr(s~>xy) - -0.375) < 0.01))
  when(lbl lbl~>xy = list(-2.125 1.25))
  term = nth(8 cv~>terminals)
  when(term
    pin = nth(0 term~>pins)
    fig = car(pin~>figs)
    bb = fig~>bBox
    w = car(cadr(bb)) - car(car(bb))
    h = cadr(cadr(bb)) - cadr(car(bb))
    fig~>bBox = list(list(-2.625 - w/2.0 0.75 - h/2.0) list(-2.625 + w/2.0 0.75 + h/2.0))
  )
  dbCreateLine(cv list("device" "drawing") list(list(-2.25 0.75) list(-2.625 0.75)))
  lbl = car(setof(s cv~>shapes s~>objType == "label" && s~>theLabel == "GIOH" && abs(car(s~>xy) - 0.2875) < 0.01 && abs(cadr(s~>xy) - -0.5) < 0.01))
  when(lbl lbl~>xy = list(-2.125 0.75))
  term = nth(7 cv~>terminals)
  when(term
    pin = nth(0 term~>pins)
    fig = car(pin~>figs)
    bb = fig~>bBox
    w = car(cadr(bb)) - car(car(bb))
    h = cadr(cadr(bb)) - cadr(car(bb))
    fig~>bBox = list(list(-2.625 - w/2.0 0.25 - h/2.0) list(-2.625 + w/2.0 0.25 + h/2.0))
  )
  dbCreateLine(cv list("device" "drawing") list(list(-2.25 0.25) list(-2.625 0.25)))
  lbl = car(setof(s cv~>shapes s~>objType == "label" && s~>theLabel == "VIOL" && abs(car(s~>xy) - 0.2875) < 0.01 && abs(cadr(s~>xy) - -0.625) < 0.01))
  when(lbl lbl~>xy = list(-2.125 0.25))
  term = nth(6 cv~>terminals)
  when(term
    pin = nth(0 term~>pins)
    fig = car(pin~>figs)
    bb = fig~>bBox
    w = car(cadr(bb)) - car(car(bb))
    h = cadr(cadr(bb)) - cadr(car(bb))
    fig~>bBox = list(list(-2.625 - w/2.0 -0.25 - h/2.0) list(-2.625 + w/2.0 -0.25 + h/2.0))
  )
  dbCreateLine(cv list("device" "drawing") list(list(-2.25 -0.25) list(-2.625 -0.25)))
  lbl = car(setof(s cv~>shapes s~>objType == "label" && s~>theLabel == "GIOL" && abs(car(s~>xy) - 0.2875) < 0.01 && abs(cadr(s~>xy) - -0.75) < 0.01))
  when(lbl lbl~>xy = list(-2.125 -0.25))
  term = nth(5 cv~>terminals)
  when(term
    pin = nth(0 term~>pins)
    fig = car(pin~>figs)
    bb = fig~>bBox
    w = car(cadr(bb)) - car(car(bb))
    h = cadr(cadr(bb)) - cadr(car(bb))
    fig~>bBox = list(list(-2.625 - w/2.0 -0.75 - h/2.0) list(-2.625 + w/2.0 -0.75 + h/2.0))
  )
  dbCreateLine(cv list("device" "drawing") list(list(-2.25 -0.75) list(-2.625 -0.75)))
  lbl = car(setof(s cv~>shapes s~>objType == "label" && s~>theLabel == "VDD3" && abs(car(s~>xy) - 0.2875) < 0.01 && abs(cadr(s~>xy) - -0.875) < 0.01))
  when(lbl lbl~>xy = list(-2.125 -0.75))
  term = nth(4 cv~>terminals)
  when(term
    pin = nth(0 term~>pins)
    fig = car(pin~>figs)
    bb = fig~>bBox
    w = car(cadr(bb)) - car(car(bb))
    h = cadr(cadr(bb)) - cadr(car(bb))
    fig~>bBox = list(list(-2.625 - w/2.0 -1.25 - h/2.0) list(-2.625 + w/2.0 -1.25 + h/2.0))
  )
  dbCreateLine(cv list("device" "drawing") list(list(-2.25 -1.25) list(-2.625 -1.25)))
  lbl = car(setof(s cv~>shapes s~>objType == "label" && s~>theLabel == "IB3" && abs(car(s~>xy) - 0.2875) < 0.01 && abs(cadr(s~>xy) - -1) < 0.01))
  when(lbl lbl~>xy = list(-2.125 -1.25))
  term = nth(3 cv~>terminals)
  when(term
    pin = nth(0 term~>pins)
    fig = car(pin~>figs)
    bb = fig~>bBox
    w = car(cadr(bb)) - car(car(bb))
    h = cadr(cadr(bb)) - cadr(car(bb))
    fig~>bBox = list(list(-2.625 - w/2.0 -1.75 - h/2.0) list(-2.625 + w/2.0 -1.75 + h/2.0))
  )
  dbCreateLine(cv list("device" "drawing") list(list(-2.25 -1.75) list(-2.625 -1.75)))
  lbl = car(setof(s cv~>shapes s~>objType == "label" && s~>theLabel == "VDD12" && abs(car(s~>xy) - 0.2875) < 0.01 && abs(cadr(s~>xy) - -1.125) < 0.01))
  when(lbl lbl~>xy = list(-2.125 -1.75))
  term = nth(2 cv~>terminals)
  when(term
    pin = nth(0 term~>pins)
    fig = car(pin~>figs)
    bb = fig~>bBox
    w = car(cadr(bb)) - car(car(bb))
    h = cadr(cadr(bb)) - cadr(car(bb))
    fig~>bBox = list(list(-2.625 - w/2.0 -2.25 - h/2.0) list(-2.625 + w/2.0 -2.25 + h/2.0))
  )
  dbCreateLine(cv list("device" "drawing") list(list(-2.25 -2.25) list(-2.625 -2.25)))
  lbl = car(setof(s cv~>shapes s~>objType == "label" && s~>theLabel == "IB12" && abs(car(s~>xy) - 0.2875) < 0.01 && abs(cadr(s~>xy) - -1.25) < 0.01))
  when(lbl lbl~>xy = list(-2.125 -2.25))
  term = nth(1 cv~>terminals)
  when(term
    pin = nth(0 term~>pins)
    fig = car(pin~>figs)
    bb = fig~>bBox
    w = car(cadr(bb)) - car(car(bb))
    h = cadr(cadr(bb)) - cadr(car(bb))
    fig~>bBox = list(list(-2.625 - w/2.0 -2.75 - h/2.0) list(-2.625 + w/2.0 -2.75 + h/2.0))
  )
  dbCreateLine(cv list("device" "drawing") list(list(-2.25 -2.75) list(-2.625 -2.75)))
  lbl = car(setof(s cv~>shapes s~>objType == "label" && s~>theLabel == "VDD_CDAC" && abs(car(s~>xy) - 0.2875) < 0.01 && abs(cadr(s~>xy) - -1.375) < 0.01))
  when(lbl lbl~>xy = list(-2.125 -2.75))
  term = nth(0 cv~>terminals)
  when(term
    pin = nth(0 term~>pins)
    fig = car(pin~>figs)
    bb = fig~>bBox
    w = car(cadr(bb)) - car(car(bb))
    h = cadr(cadr(bb)) - cadr(car(bb))
    fig~>bBox = list(list(-2.625 - w/2.0 -3.25 - h/2.0) list(-2.625 + w/2.0 -3.25 + h/2.0))
  )
  dbCreateLine(cv list("device" "drawing") list(list(-2.25 -3.25) list(-2.625 -3.25)))
  lbl = car(setof(s cv~>shapes s~>objType == "label" && s~>theLabel == "VREFDES" && abs(car(s~>xy) - 0.2875) < 0.01 && abs(cadr(s~>xy) - -1.5) < 0.01))
  when(lbl lbl~>xy = list(-2.125 -3.25))
  term = nth(28 cv~>terminals)
  when(term
    pin = nth(0 term~>pins)
    fig = car(pin~>figs)
    bb = fig~>bBox
    w = car(cadr(bb)) - car(car(bb))
    h = cadr(cadr(bb)) - cadr(car(bb))
    fig~>bBox = list(list(7.625 - w/2.0 2.25 - h/2.0) list(7.625 + w/2.0 2.25 + h/2.0))
  )
  dbCreateLine(cv list("device" "drawing") list(list(7.25 2.25) list(7.625 2.25)))
  lbl = car(setof(s cv~>shapes s~>objType == "label" && s~>theLabel == "VREFN" && abs(car(s~>xy) - 4.5875) < 0.01 && abs(cadr(s~>xy) - 0) < 0.01))
  when(lbl lbl~>xy = list(7.125 2.25))
  term = nth(26 cv~>terminals)
  when(term
    pin = nth(0 term~>pins)
    fig = car(pin~>figs)
    bb = fig~>bBox
    w = car(cadr(bb)) - car(car(bb))
    h = cadr(cadr(bb)) - cadr(car(bb))
    fig~>bBox = list(list(7.625 - w/2.0 1.75 - h/2.0) list(7.625 + w/2.0 1.75 + h/2.0))
  )
  dbCreateLine(cv list("device" "drawing") list(list(7.25 1.75) list(7.625 1.75)))
  lbl = car(setof(s cv~>shapes s~>objType == "label" && s~>theLabel == "VREFM" && abs(car(s~>xy) - 4.5875) < 0.01 && abs(cadr(s~>xy) - -0.25) < 0.01))
  when(lbl lbl~>xy = list(7.125 1.75))
  term = nth(25 cv~>terminals)
  when(term
    pin = nth(0 term~>pins)
    fig = car(pin~>figs)
    bb = fig~>bBox
    w = car(cadr(bb)) - car(car(bb))
    h = cadr(cadr(bb)) - cadr(car(bb))
    fig~>bBox = list(list(7.625 - w/2.0 1.25 - h/2.0) list(7.625 + w/2.0 1.25 + h/2.0))
  )
  dbCreateLine(cv list("device" "drawing") list(list(7.25 1.25) list(7.625 1.25)))
  lbl = car(setof(s cv~>shapes s~>objType == "label" && s~>theLabel == "VREFH" && abs(car(s~>xy) - 4.5875) < 0.01 && abs(cadr(s~>xy) - -0.375) < 0.01))
  when(lbl lbl~>xy = list(7.125 1.25))
  term = nth(23 cv~>terminals)
  when(term
    pin = nth(0 term~>pins)
    fig = car(pin~>figs)
    bb = fig~>bBox
    w = car(cadr(bb)) - car(car(bb))
    h = cadr(cadr(bb)) - cadr(car(bb))
    fig~>bBox = list(list(7.625 - w/2.0 0.75 - h/2.0) list(7.625 + w/2.0 0.75 + h/2.0))
  )
  dbCreateLine(cv list("device" "drawing") list(list(7.25 0.75) list(7.625 0.75)))
  lbl = car(setof(s cv~>shapes s~>objType == "label" && s~>theLabel == "VSSSAR" && abs(car(s~>xy) - 4.5875) < 0.01 && abs(cadr(s~>xy) - -0.625) < 0.01))
  when(lbl lbl~>xy = list(7.125 0.75))
  term = nth(22 cv~>terminals)
  when(term
    pin = nth(0 term~>pins)
    fig = car(pin~>figs)
    bb = fig~>bBox
    w = car(cadr(bb)) - car(car(bb))
    h = cadr(cadr(bb)) - cadr(car(bb))
    fig~>bBox = list(list(7.625 - w/2.0 0.25 - h/2.0) list(7.625 + w/2.0 0.25 + h/2.0))
  )
  dbCreateLine(cv list("device" "drawing") list(list(7.25 0.25) list(7.625 0.25)))
  lbl = car(setof(s cv~>shapes s~>objType == "label" && s~>theLabel == "VDDSAR" && abs(car(s~>xy) - 4.5875) < 0.01 && abs(cadr(s~>xy) - -0.75) < 0.01))
  when(lbl lbl~>xy = list(7.125 0.25))
  term = nth(21 cv~>terminals)
  when(term
    pin = nth(0 term~>pins)
    fig = car(pin~>figs)
    bb = fig~>bBox
    w = car(cadr(bb)) - car(car(bb))
    h = cadr(cadr(bb)) - cadr(car(bb))
    fig~>bBox = list(list(7.625 - w/2.0 -0.25 - h/2.0) list(7.625 + w/2.0 -0.25 + h/2.0))
  )
  dbCreateLine(cv list("device" "drawing") list(list(7.25 -0.25) list(7.625 -0.25)))
  lbl = car(setof(s cv~>shapes s~>objType == "label" && s~>theLabel == "VDDCLK" && abs(car(s~>xy) - 4.5875) < 0.01 && abs(cadr(s~>xy) - -0.875) < 0.01))
  when(lbl lbl~>xy = list(7.125 -0.25))
  term = nth(20 cv~>terminals)
  when(term
    pin = nth(0 term~>pins)
    fig = car(pin~>figs)
    bb = fig~>bBox
    w = car(cadr(bb)) - car(car(bb))
    h = cadr(cadr(bb)) - cadr(car(bb))
    fig~>bBox = list(list(7.625 - w/2.0 -0.75 - h/2.0) list(7.625 + w/2.0 -0.75 + h/2.0))
  )
  dbCreateLine(cv list("device" "drawing") list(list(7.25 -0.75) list(7.625 -0.75)))
  lbl = car(setof(s cv~>shapes s~>objType == "label" && s~>theLabel == "VSSCLK" && abs(car(s~>xy) - 4.5875) < 0.01 && abs(cadr(s~>xy) - -1) < 0.01))
  when(lbl lbl~>xy = list(7.125 -0.75))
  term = nth(19 cv~>terminals)
  when(term
    pin = nth(0 term~>pins)
    fig = car(pin~>figs)
    bb = fig~>bBox
    w = car(cadr(bb)) - car(car(bb))
    h = cadr(cadr(bb)) - cadr(car(bb))
    fig~>bBox = list(list(7.625 - w/2.0 -1.25 - h/2.0) list(7.625 + w/2.0 -1.25 + h/2.0))
  )
  dbCreateLine(cv list("device" "drawing") list(list(7.25 -1.25) list(7.625 -1.25)))
  lbl = car(setof(s cv~>shapes s~>objType == "label" && s~>theLabel == "VCM" && abs(car(s~>xy) - 4.5875) < 0.01 && abs(cadr(s~>xy) - -1.125) < 0.01))
  when(lbl lbl~>xy = list(7.125 -1.25))
  term = nth(18 cv~>terminals)
  when(term
    pin = nth(0 term~>pins)
    fig = car(pin~>figs)
    bb = fig~>bBox
    w = car(cadr(bb)) - car(car(bb))
    h = cadr(cadr(bb)) - cadr(car(bb))
    fig~>bBox = list(list(7.625 - w/2.0 -1.75 - h/2.0) list(7.625 + w/2.0 -1.75 + h/2.0))
  )
  dbCreateLine(cv list("device" "drawing") list(list(7.25 -1.75) list(7.625 -1.75)))
  lbl = car(setof(s cv~>shapes s~>objType == "label" && s~>theLabel == "VDD_DAT" && abs(car(s~>xy) - 4.5875) < 0.01 && abs(cadr(s~>xy) - -1.25) < 0.01))
  when(lbl lbl~>xy = list(7.125 -1.75))
  term = nth(16 cv~>terminals)
  when(term
    pin = nth(0 term~>pins)
    fig = car(pin~>figs)
    bb = fig~>bBox
    w = car(cadr(bb)) - car(car(bb))
    h = cadr(cadr(bb)) - cadr(car(bb))
    fig~>bBox = list(list(7.625 - w/2.0 -2.25 - h/2.0) list(7.625 + w/2.0 -2.25 + h/2.0))
  )
  dbCreateLine(cv list("device" "drawing") list(list(7.25 -2.25) list(7.625 -2.25)))
  lbl = car(setof(s cv~>shapes s~>objType == "label" && s~>theLabel == "GND_DAT" && abs(car(s~>xy) - 4.5875) < 0.01 && abs(cadr(s~>xy) - -1.5) < 0.01))
  when(lbl lbl~>xy = list(7.125 -2.25))
  term = nth(14 cv~>terminals)
  when(term
    pin = nth(0 term~>pins)
    fig = car(pin~>figs)
    bb = fig~>bBox
    w = car(cadr(bb)) - car(car(bb))
    h = cadr(cadr(bb)) - cadr(car(bb))
    fig~>bBox = list(list(7.625 - w/2.0 -2.75 - h/2.0) list(7.625 + w/2.0 -2.75 + h/2.0))
  )
  dbCreateLine(cv list("device" "drawing") list(list(7.25 -2.75) list(7.625 -2.75)))
  lbl = car(setof(s cv~>shapes s~>objType == "label" && s~>theLabel == "CLKN" && abs(car(s~>xy) - 4.5875) < 0.01 && abs(cadr(s~>xy) - -1.75) < 0.01))
  when(lbl lbl~>xy = list(7.125 -2.75))
  term = nth(13 cv~>terminals)
  when(term
    pin = nth(0 term~>pins)
    fig = car(pin~>figs)
    bb = fig~>bBox
    w = car(cadr(bb)) - car(car(bb))
    h = cadr(cadr(bb)) - cadr(car(bb))
    fig~>bBox = list(list(7.625 - w/2.0 -3.25 - h/2.0) list(7.625 + w/2.0 -3.25 + h/2.0))
  )
  dbCreateLine(cv list("device" "drawing") list(list(7.25 -3.25) list(7.625 -3.25)))
  lbl = car(setof(s cv~>shapes s~>objType == "label" && s~>theLabel == "CLKP" && abs(car(s~>xy) - 4.5875) < 0.01 && abs(cadr(s~>xy) - -1.875) < 0.01))
  when(lbl lbl~>xy = list(7.125 -3.25))
  term = nth(30 cv~>terminals)
  when(term
    pin = nth(0 term~>pins)
    fig = car(pin~>figs)
    bb = fig~>bBox
    w = car(cadr(bb)) - car(car(bb))
    h = cadr(cadr(bb)) - cadr(car(bb))
    fig~>bBox = list(list(-0.25 - w/2.0 4.625 - h/2.0) list(-0.25 + w/2.0 4.625 + h/2.0))
  )
  dbCreateLine(cv list("device" "drawing") list(list(-0.25 4.25) list(-0.25 4.625)))
  lbl = car(setof(s cv~>shapes s~>objType == "label" && s~>theLabel == "D4" && abs(car(s~>xy) - 1.1875) < 0.01 && abs(cadr(s~>xy) - 0.775) < 0.01))
  when(lbl lbl~>xy = list(-0.25 4.125))
  term = nth(32 cv~>terminals)
  when(term
    pin = nth(0 term~>pins)
    fig = car(pin~>figs)
    bb = fig~>bBox
    w = car(cadr(bb)) - car(car(bb))
    h = cadr(cadr(bb)) - cadr(car(bb))
    fig~>bBox = list(list(0.25 - w/2.0 4.625 - h/2.0) list(0.25 + w/2.0 4.625 + h/2.0))
  )
  dbCreateLine(cv list("device" "drawing") list(list(0.25 4.25) list(0.25 4.625)))
  lbl = car(setof(s cv~>shapes s~>objType == "label" && s~>theLabel == "D3" && abs(car(s~>xy) - 1.4375) < 0.01 && abs(cadr(s~>xy) - 0.775) < 0.01))
  when(lbl lbl~>xy = list(0.25 4.125))
  term = nth(34 cv~>terminals)
  when(term
    pin = nth(0 term~>pins)
    fig = car(pin~>figs)
    bb = fig~>bBox
    w = car(cadr(bb)) - car(car(bb))
    h = cadr(cadr(bb)) - cadr(car(bb))
    fig~>bBox = list(list(0.75 - w/2.0 4.625 - h/2.0) list(0.75 + w/2.0 4.625 + h/2.0))
  )
  dbCreateLine(cv list("device" "drawing") list(list(0.75 4.25) list(0.75 4.625)))
  lbl = car(setof(s cv~>shapes s~>objType == "label" && s~>theLabel == "D2" && abs(car(s~>xy) - 1.6875) < 0.01 && abs(cadr(s~>xy) - 0.775) < 0.01))
  when(lbl lbl~>xy = list(0.75 4.125))
  term = nth(36 cv~>terminals)
  when(term
    pin = nth(0 term~>pins)
    fig = car(pin~>figs)
    bb = fig~>bBox
    w = car(cadr(bb)) - car(car(bb))
    h = cadr(cadr(bb)) - cadr(car(bb))
    fig~>bBox = list(list(1.25 - w/2.0 4.625 - h/2.0) list(1.25 + w/2.0 4.625 + h/2.0))
  )
  dbCreateLine(cv list("device" "drawing") list(list(1.25 4.25) list(1.25 4.625)))
  lbl = car(setof(s cv~>shapes s~>objType == "label" && s~>theLabel == "D1" && abs(car(s~>xy) - 1.9375) < 0.01 && abs(cadr(s~>xy) - 0.775) < 0.01))
  when(lbl lbl~>xy = list(1.25 4.125))
  term = nth(38 cv~>terminals)
  when(term
    pin = nth(0 term~>pins)
    fig = car(pin~>figs)
    bb = fig~>bBox
    w = car(cadr(bb)) - car(car(bb))
    h = cadr(cadr(bb)) - cadr(car(bb))
    fig~>bBox = list(list(1.75 - w/2.0 4.625 - h/2.0) list(1.75 + w/2.0 4.625 + h/2.0))
  )
  dbCreateLine(cv list("device" "drawing") list(list(1.75 4.25) list(1.75 4.625)))
  lbl = car(setof(s cv~>shapes s~>objType == "label" && s~>theLabel == "D0" && abs(car(s~>xy) - 2.1875) < 0.01 && abs(cadr(s~>xy) - 0.775) < 0.01))
  when(lbl lbl~>xy = list(1.75 4.125))
  term = nth(40 cv~>terminals)
  when(term
    pin = nth(0 term~>pins)
    fig = car(pin~>figs)
    bb = fig~>bBox
    w = car(cadr(bb)) - car(car(bb))
    h = cadr(cadr(bb)) - cadr(car(bb))
    fig~>bBox = list(list(2.25 - w/2.0 4.625 - h/2.0) list(2.25 + w/2.0 4.625 + h/2.0))
  )
  dbCreateLine(cv list("device" "drawing") list(list(2.25 4.25) list(2.25 4.625)))
  lbl = car(setof(s cv~>shapes s~>objType == "label" && s~>theLabel == "RST" && abs(car(s~>xy) - 2.4375) < 0.01 && abs(cadr(s~>xy) - 0.775) < 0.01))
  when(lbl lbl~>xy = list(2.25 4.125))
  term = nth(42 cv~>terminals)
  when(term
    pin = nth(0 term~>pins)
    fig = car(pin~>figs)
    bb = fig~>bBox
    w = car(cadr(bb)) - car(car(bb))
    h = cadr(cadr(bb)) - cadr(car(bb))
    fig~>bBox = list(list(2.75 - w/2.0 4.625 - h/2.0) list(2.75 + w/2.0 4.625 + h/2.0))
  )
  dbCreateLine(cv list("device" "drawing") list(list(2.75 4.25) list(2.75 4.625)))
  lbl = car(setof(s cv~>shapes s~>objType == "label" && s~>theLabel == "SDO" && abs(car(s~>xy) - 2.6875) < 0.01 && abs(cadr(s~>xy) - 0.775) < 0.01))
  when(lbl lbl~>xy = list(2.75 4.125))
  term = nth(44 cv~>terminals)
  when(term
    pin = nth(0 term~>pins)
    fig = car(pin~>figs)
    bb = fig~>bBox
    w = car(cadr(bb)) - car(car(bb))
    h = cadr(cadr(bb)) - cadr(car(bb))
    fig~>bBox = list(list(3.25 - w/2.0 4.625 - h/2.0) list(3.25 + w/2.0 4.625 + h/2.0))
  )
  dbCreateLine(cv list("device" "drawing") list(list(3.25 4.25) list(3.25 4.625)))
  lbl = car(setof(s cv~>shapes s~>objType == "label" && s~>theLabel == "SCK" && abs(car(s~>xy) - 2.9375) < 0.01 && abs(cadr(s~>xy) - 0.775) < 0.01))
  when(lbl lbl~>xy = list(3.25 4.125))
  term = nth(46 cv~>terminals)
  when(term
    pin = nth(0 term~>pins)
    fig = car(pin~>figs)
    bb = fig~>bBox
    w = car(cadr(bb)) - car(car(bb))
    h = cadr(cadr(bb)) - cadr(car(bb))
    fig~>bBox = list(list(3.75 - w/2.0 4.625 - h/2.0) list(3.75 + w/2.0 4.625 + h/2.0))
  )
  dbCreateLine(cv list("device" "drawing") list(list(3.75 4.25) list(3.75 4.625)))
  lbl = car(setof(s cv~>shapes s~>objType == "label" && s~>theLabel == "SDI" && abs(car(s~>xy) - 3.1875) < 0.01 && abs(cadr(s~>xy) - 0.775) < 0.01))
  when(lbl lbl~>xy = list(3.75 4.125))
  term = nth(48 cv~>terminals)
  when(term
    pin = nth(0 term~>pins)
    fig = car(pin~>figs)
    bb = fig~>bBox
    w = car(cadr(bb)) - car(car(bb))
    h = cadr(cadr(bb)) - cadr(car(bb))
    fig~>bBox = list(list(4.25 - w/2.0 4.625 - h/2.0) list(4.25 + w/2.0 4.625 + h/2.0))
  )
  dbCreateLine(cv list("device" "drawing") list(list(4.25 4.25) list(4.25 4.625)))
  lbl = car(setof(s cv~>shapes s~>objType == "label" && s~>theLabel == "SLP" && abs(car(s~>xy) - 3.4375) < 0.01 && abs(cadr(s~>xy) - 0.775) < 0.01))
  when(lbl lbl~>xy = list(4.25 4.125))
  term = nth(50 cv~>terminals)
  when(term
    pin = nth(0 term~>pins)
    fig = car(pin~>figs)
    bb = fig~>bBox
    w = car(cadr(bb)) - car(car(bb))
    h = cadr(cadr(bb)) - cadr(car(bb))
    fig~>bBox = list(list(4.75 - w/2.0 4.625 - h/2.0) list(4.75 + w/2.0 4.625 + h/2.0))
  )
  dbCreateLine(cv list("device" "drawing") list(list(4.75 4.25) list(4.75 4.625)))
  lbl = car(setof(s cv~>shapes s~>objType == "label" && s~>theLabel == "VREFDES2" && abs(car(s~>xy) - 3.6875) < 0.01 && abs(cadr(s~>xy) - 0.775) < 0.01))
  when(lbl lbl~>xy = list(4.75 4.125))
  term = nth(51 cv~>terminals)
  when(term
    pin = nth(0 term~>pins)
    fig = car(pin~>figs)
    bb = fig~>bBox
    w = car(cadr(bb)) - car(car(bb))
    h = cadr(cadr(bb)) - cadr(car(bb))
    fig~>bBox = list(list(5.25 - w/2.0 4.625 - h/2.0) list(5.25 + w/2.0 4.625 + h/2.0))
  )
  dbCreateLine(cv list("device" "drawing") list(list(5.25 4.25) list(5.25 4.625)))
  lbl = car(setof(s cv~>shapes s~>objType == "label" && s~>theLabel == "IBREF2" && abs(car(s~>xy) - 3.8125) < 0.01 && abs(cadr(s~>xy) - 0.775) < 0.01))
  when(lbl lbl~>xy = list(5.25 4.125))
  term = nth(52 cv~>terminals)
  when(term
    pin = nth(0 term~>pins)
    fig = car(pin~>figs)
    bb = fig~>bBox
    w = car(cadr(bb)) - car(car(bb))
    h = cadr(cadr(bb)) - cadr(car(bb))
    fig~>bBox = list(list(-0.25 - w/2.0 -5.625 - h/2.0) list(-0.25 + w/2.0 -5.625 + h/2.0))
  )
  dbCreateLine(cv list("device" "drawing") list(list(-0.25 -5.25) list(-0.25 -5.625)))
  lbl = car(setof(s cv~>shapes s~>objType == "label" && s~>theLabel == "IBREF" && abs(car(s~>xy) - 1.0625) < 0.01 && abs(cadr(s~>xy) - -2.65) < 0.01))
  when(lbl lbl~>xy = list(-0.25 -5.125))
  term = nth(53 cv~>terminals)
  when(term
    pin = nth(1 term~>pins)
    fig = car(pin~>figs)
    bb = fig~>bBox
    w = car(cadr(bb)) - car(car(bb))
    h = cadr(cadr(bb)) - cadr(car(bb))
    fig~>bBox = list(list(0.25 - w/2.0 -5.625 - h/2.0) list(0.25 + w/2.0 -5.625 + h/2.0))
  )
  dbCreateLine(cv list("device" "drawing") list(list(0.25 -5.25) list(0.25 -5.625)))
  lbl = car(setof(s cv~>shapes s~>objType == "label" && s~>theLabel == "VSS" && abs(car(s~>xy) - 1.1875) < 0.01 && abs(cadr(s~>xy) - -2.65) < 0.01))
  when(lbl lbl~>xy = list(0.25 -5.125))
  term = nth(54 cv~>terminals)
  when(term
    pin = nth(0 term~>pins)
    fig = car(pin~>figs)
    bb = fig~>bBox
    w = car(cadr(bb)) - car(car(bb))
    h = cadr(cadr(bb)) - cadr(car(bb))
    fig~>bBox = list(list(0.75 - w/2.0 -5.625 - h/2.0) list(0.75 + w/2.0 -5.625 + h/2.0))
  )
  dbCreateLine(cv list("device" "drawing") list(list(0.75 -5.25) list(0.75 -5.625)))
  lbl = car(setof(s cv~>shapes s~>objType == "label" && s~>theLabel == "IBUF_IBIAS" && abs(car(s~>xy) - 1.3125) < 0.01 && abs(cadr(s~>xy) - -2.65) < 0.01))
  when(lbl lbl~>xy = list(0.75 -5.125))
  term = nth(53 cv~>terminals)
  when(term
    pin = nth(0 term~>pins)
    fig = car(pin~>figs)
    bb = fig~>bBox
    w = car(cadr(bb)) - car(car(bb))
    h = cadr(cadr(bb)) - cadr(car(bb))
    fig~>bBox = list(list(1.25 - w/2.0 -5.625 - h/2.0) list(1.25 + w/2.0 -5.625 + h/2.0))
  )
  dbCreateLine(cv list("device" "drawing") list(list(1.25 -5.25) list(1.25 -5.625)))
  lbl = car(setof(s cv~>shapes s~>objType == "label" && s~>theLabel == "VSS" && abs(car(s~>xy) - 1.4375) < 0.01 && abs(cadr(s~>xy) - -2.65) < 0.01))
  when(lbl lbl~>xy = list(1.25 -5.125))
  term = nth(56 cv~>terminals)
  when(term
    pin = nth(0 term~>pins)
    fig = car(pin~>figs)
    bb = fig~>bBox
    w = car(cadr(bb)) - car(car(bb))
    h = cadr(cadr(bb)) - cadr(car(bb))
    fig~>bBox = list(list(1.75 - w/2.0 -5.625 - h/2.0) list(1.75 + w/2.0 -5.625 + h/2.0))
  )
  dbCreateLine(cv list("device" "drawing") list(list(1.75 -5.25) list(1.75 -5.625)))
  lbl = car(setof(s cv~>shapes s~>objType == "label" && s~>theLabel == "VDDIB" && abs(car(s~>xy) - 1.6875) < 0.01 && abs(cadr(s~>xy) - -2.65) < 0.01))
  when(lbl lbl~>xy = list(1.75 -5.125))
  term = nth(57 cv~>terminals)
  when(term
    pin = nth(1 term~>pins)
    fig = car(pin~>figs)
    bb = fig~>bBox
    w = car(cadr(bb)) - car(car(bb))
    h = cadr(cadr(bb)) - cadr(car(bb))
    fig~>bBox = list(list(2.25 - w/2.0 -5.625 - h/2.0) list(2.25 + w/2.0 -5.625 + h/2.0))
  )
  dbCreateLine(cv list("device" "drawing") list(list(2.25 -5.25) list(2.25 -5.625)))
  lbl = car(setof(s cv~>shapes s~>objType == "label" && s~>theLabel == "VSSIB" && abs(car(s~>xy) - 1.8125) < 0.01 && abs(cadr(s~>xy) - -2.65) < 0.01))
  when(lbl lbl~>xy = list(2.25 -5.125))
  term = nth(58 cv~>terminals)
  when(term
    pin = nth(0 term~>pins)
    fig = car(pin~>figs)
    bb = fig~>bBox
    w = car(cadr(bb)) - car(car(bb))
    h = cadr(cadr(bb)) - cadr(car(bb))
    fig~>bBox = list(list(2.75 - w/2.0 -5.625 - h/2.0) list(2.75 + w/2.0 -5.625 + h/2.0))
  )
  dbCreateLine(cv list("device" "drawing") list(list(2.75 -5.25) list(2.75 -5.625)))
  lbl = car(setof(s cv~>shapes s~>objType == "label" && s~>theLabel == "VINN" && abs(car(s~>xy) - 1.9375) < 0.01 && abs(cadr(s~>xy) - -2.65) < 0.01))
  when(lbl lbl~>xy = list(2.75 -5.125))
  term = nth(59 cv~>terminals)
  when(term
    pin = nth(0 term~>pins)
    fig = car(pin~>figs)
    bb = fig~>bBox
    w = car(cadr(bb)) - car(car(bb))
    h = cadr(cadr(bb)) - cadr(car(bb))
    fig~>bBox = list(list(3.25 - w/2.0 -5.625 - h/2.0) list(3.25 + w/2.0 -5.625 + h/2.0))
  )
  dbCreateLine(cv list("device" "drawing") list(list(3.25 -5.25) list(3.25 -5.625)))
  lbl = car(setof(s cv~>shapes s~>objType == "label" && s~>theLabel == "VINP" && abs(car(s~>xy) - 2.0625) < 0.01 && abs(cadr(s~>xy) - -2.65) < 0.01))
  when(lbl lbl~>xy = list(3.25 -5.125))
  term = nth(57 cv~>terminals)
  when(term
    pin = nth(0 term~>pins)
    fig = car(pin~>figs)
    bb = fig~>bBox
    w = car(cadr(bb)) - car(car(bb))
    h = cadr(cadr(bb)) - cadr(car(bb))
    fig~>bBox = list(list(3.75 - w/2.0 -5.625 - h/2.0) list(3.75 + w/2.0 -5.625 + h/2.0))
  )
  dbCreateLine(cv list("device" "drawing") list(list(3.75 -5.25) list(3.75 -5.625)))
  lbl = car(setof(s cv~>shapes s~>objType == "label" && s~>theLabel == "VSSIB" && abs(car(s~>xy) - 2.3125) < 0.01 && abs(cadr(s~>xy) - -2.65) < 0.01))
  when(lbl lbl~>xy = list(3.75 -5.125))
  term = nth(61 cv~>terminals)
  when(term
    pin = nth(0 term~>pins)
    fig = car(pin~>figs)
    bb = fig~>bBox
    w = car(cadr(bb)) - car(car(bb))
    h = cadr(cadr(bb)) - cadr(car(bb))
    fig~>bBox = list(list(4.25 - w/2.0 -5.625 - h/2.0) list(4.25 + w/2.0 -5.625 + h/2.0))
  )
  dbCreateLine(cv list("device" "drawing") list(list(4.25 -5.25) list(4.25 -5.625)))
  lbl = car(setof(s cv~>shapes s~>objType == "label" && s~>theLabel == "VINCM" && abs(car(s~>xy) - 2.4375) < 0.01 && abs(cadr(s~>xy) - -2.65) < 0.01))
  when(lbl lbl~>xy = list(4.25 -5.125))
  term = nth(63 cv~>terminals)
  when(term
    pin = nth(0 term~>pins)
    fig = car(pin~>figs)
    bb = fig~>bBox
    w = car(cadr(bb)) - car(car(bb))
    h = cadr(cadr(bb)) - cadr(car(bb))
    fig~>bBox = list(list(4.75 - w/2.0 -5.625 - h/2.0) list(4.75 + w/2.0 -5.625 + h/2.0))
  )
  dbCreateLine(cv list("device" "drawing") list(list(4.75 -5.25) list(4.75 -5.625)))
  lbl = car(setof(s cv~>shapes s~>objType == "label" && s~>theLabel == "VDD_CKB" && abs(car(s~>xy) - 2.6875) < 0.01 && abs(cadr(s~>xy) - -2.65) < 0.01))
  when(lbl lbl~>xy = list(4.75 -5.125))
  term = nth(65 cv~>terminals)
  when(term
    pin = nth(0 term~>pins)
    fig = car(pin~>figs)
    bb = fig~>bBox
    w = car(cadr(bb)) - car(car(bb))
    h = cadr(cadr(bb)) - cadr(car(bb))
    fig~>bBox = list(list(5.25 - w/2.0 -5.625 - h/2.0) list(5.25 + w/2.0 -5.625 + h/2.0))
  )
  dbCreateLine(cv list("device" "drawing") list(list(5.25 -5.25) list(5.25 -5.625)))
  lbl = car(setof(s cv~>shapes s~>objType == "label" && s~>theLabel == "GND_CKB" && abs(car(s~>xy) - 2.9375) < 0.01 && abs(cadr(s~>xy) - -2.65) < 0.01))
  when(lbl lbl~>xy = list(5.25 -5.125))
  term = nth(11 cv~>terminals)
  when(term
    pin = nth(0 term~>pins)
    fig = car(pin~>figs)
    bb = fig~>bBox
    w = car(cadr(bb)) - car(car(bb))
    h = cadr(cadr(bb)) - cadr(car(bb))
    fig~>bBox = list(list(-1 - w/2.0 1.75 - h/2.0) list(-1 + w/2.0 1.75 + h/2.0))
  )
  lbl = car(setof(s cv~>shapes s~>objType == "label" && s~>theLabel == "SYNC_CORE" && abs(car(s~>xy) - 0.2875) < 0.01 && abs(cadr(s~>xy) - -0.125) < 0.01))
  when(lbl dbDeleteObject(lbl))
  term = nth(27 cv~>terminals)
  when(term
    pin = nth(0 term~>pins)
    fig = car(pin~>figs)
    bb = fig~>bBox
    w = car(cadr(bb)) - car(car(bb))
    h = cadr(cadr(bb)) - cadr(car(bb))
    fig~>bBox = list(list(6 - w/2.0 2.25 - h/2.0) list(6 + w/2.0 2.25 + h/2.0))
  )
  lbl = car(setof(s cv~>shapes s~>objType == "label" && s~>theLabel == "VREFN_CORE" && abs(car(s~>xy) - 4.5875) < 0.01 && abs(cadr(s~>xy) - -0.125) < 0.01))
  when(lbl dbDeleteObject(lbl))
  term = nth(24 cv~>terminals)
  when(term
    pin = nth(0 term~>pins)
    fig = car(pin~>figs)
    bb = fig~>bBox
    w = car(cadr(bb)) - car(car(bb))
    h = cadr(cadr(bb)) - cadr(car(bb))
    fig~>bBox = list(list(6 - w/2.0 1.25 - h/2.0) list(6 + w/2.0 1.25 + h/2.0))
  )
  lbl = car(setof(s cv~>shapes s~>objType == "label" && s~>theLabel == "VREFH_CORE" && abs(car(s~>xy) - 4.5875) < 0.01 && abs(cadr(s~>xy) - -0.5) < 0.01))
  when(lbl dbDeleteObject(lbl))
  term = nth(17 cv~>terminals)
  when(term
    pin = nth(0 term~>pins)
    fig = car(pin~>figs)
    bb = fig~>bBox
    w = car(cadr(bb)) - car(car(bb))
    h = cadr(cadr(bb)) - cadr(car(bb))
    fig~>bBox = list(list(6 - w/2.0 -1.75 - h/2.0) list(6 + w/2.0 -1.75 + h/2.0))
  )
  lbl = car(setof(s cv~>shapes s~>objType == "label" && s~>theLabel == "VDD_DAT_CORE" && abs(car(s~>xy) - 4.5875) < 0.01 && abs(cadr(s~>xy) - -1.375) < 0.01))
  when(lbl dbDeleteObject(lbl))
  term = nth(15 cv~>terminals)
  when(term
    pin = nth(0 term~>pins)
    fig = car(pin~>figs)
    bb = fig~>bBox
    w = car(cadr(bb)) - car(car(bb))
    h = cadr(cadr(bb)) - cadr(car(bb))
    fig~>bBox = list(list(6 - w/2.0 -2.25 - h/2.0) list(6 + w/2.0 -2.25 + h/2.0))
  )
  lbl = car(setof(s cv~>shapes s~>objType == "label" && s~>theLabel == "GND_DAT_CORE" && abs(car(s~>xy) - 4.5875) < 0.01 && abs(cadr(s~>xy) - -1.625) < 0.01))
  when(lbl dbDeleteObject(lbl))
  term = nth(29 cv~>terminals)
  when(term
    pin = nth(0 term~>pins)
    fig = car(pin~>figs)
    bb = fig~>bBox
    w = car(cadr(bb)) - car(car(bb))
    h = cadr(cadr(bb)) - cadr(car(bb))
    fig~>bBox = list(list(-1 - w/2.0 2.25 - h/2.0) list(-1 + w/2.0 2.25 + h/2.0))
  )
  lbl = car(setof(s cv~>shapes s~>objType == "label" && s~>theLabel == "DCLK_CORE" && abs(car(s~>xy) - 1.0625) < 0.01 && abs(cadr(s~>xy) - 0.775) < 0.01))
  when(lbl dbDeleteObject(lbl))
  term = nth(31 cv~>terminals)
  when(term
    pin = nth(0 term~>pins)
    fig = car(pin~>figs)
    bb = fig~>bBox
    w = car(cadr(bb)) - car(car(bb))
    h = cadr(cadr(bb)) - cadr(car(bb))
    fig~>bBox = list(list(-0.25 - w/2.0 3 - h/2.0) list(-0.25 + w/2.0 3 + h/2.0))
  )
  lbl = car(setof(s cv~>shapes s~>objType == "label" && s~>theLabel == "D4_CORE" && abs(car(s~>xy) - 1.3125) < 0.01 && abs(cadr(s~>xy) - 0.775) < 0.01))
  when(lbl dbDeleteObject(lbl))
  term = nth(33 cv~>terminals)
  when(term
    pin = nth(0 term~>pins)
    fig = car(pin~>figs)
    bb = fig~>bBox
    w = car(cadr(bb)) - car(car(bb))
    h = cadr(cadr(bb)) - cadr(car(bb))
    fig~>bBox = list(list(0.25 - w/2.0 3 - h/2.0) list(0.25 + w/2.0 3 + h/2.0))
  )
  lbl = car(setof(s cv~>shapes s~>objType == "label" && s~>theLabel == "D3_CORE" && abs(car(s~>xy) - 1.5625) < 0.01 && abs(cadr(s~>xy) - 0.775) < 0.01))
  when(lbl dbDeleteObject(lbl))
  term = nth(35 cv~>terminals)
  when(term
    pin = nth(0 term~>pins)
    fig = car(pin~>figs)
    bb = fig~>bBox
    w = car(cadr(bb)) - car(car(bb))
    h = cadr(cadr(bb)) - cadr(car(bb))
    fig~>bBox = list(list(0.75 - w/2.0 3 - h/2.0) list(0.75 + w/2.0 3 + h/2.0))
  )
  lbl = car(setof(s cv~>shapes s~>objType == "label" && s~>theLabel == "D2_CORE" && abs(car(s~>xy) - 1.8125) < 0.01 && abs(cadr(s~>xy) - 0.775) < 0.01))
  when(lbl dbDeleteObject(lbl))
  term = nth(37 cv~>terminals)
  when(term
    pin = nth(0 term~>pins)
    fig = car(pin~>figs)
    bb = fig~>bBox
    w = car(cadr(bb)) - car(car(bb))
    h = cadr(cadr(bb)) - cadr(car(bb))
    fig~>bBox = list(list(1.25 - w/2.0 3 - h/2.0) list(1.25 + w/2.0 3 + h/2.0))
  )
  lbl = car(setof(s cv~>shapes s~>objType == "label" && s~>theLabel == "D1_CORE" && abs(car(s~>xy) - 2.0625) < 0.01 && abs(cadr(s~>xy) - 0.775) < 0.01))
  when(lbl dbDeleteObject(lbl))
  term = nth(39 cv~>terminals)
  when(term
    pin = nth(0 term~>pins)
    fig = car(pin~>figs)
    bb = fig~>bBox
    w = car(cadr(bb)) - car(car(bb))
    h = cadr(cadr(bb)) - cadr(car(bb))
    fig~>bBox = list(list(1.75 - w/2.0 3 - h/2.0) list(1.75 + w/2.0 3 + h/2.0))
  )
  lbl = car(setof(s cv~>shapes s~>objType == "label" && s~>theLabel == "D0_CORE" && abs(car(s~>xy) - 2.3125) < 0.01 && abs(cadr(s~>xy) - 0.775) < 0.01))
  when(lbl dbDeleteObject(lbl))
  term = nth(41 cv~>terminals)
  when(term
    pin = nth(0 term~>pins)
    fig = car(pin~>figs)
    bb = fig~>bBox
    w = car(cadr(bb)) - car(car(bb))
    h = cadr(cadr(bb)) - cadr(car(bb))
    fig~>bBox = list(list(2.25 - w/2.0 3 - h/2.0) list(2.25 + w/2.0 3 + h/2.0))
  )
  lbl = car(setof(s cv~>shapes s~>objType == "label" && s~>theLabel == "RST_CORE" && abs(car(s~>xy) - 2.5625) < 0.01 && abs(cadr(s~>xy) - 0.775) < 0.01))
  when(lbl dbDeleteObject(lbl))
  term = nth(43 cv~>terminals)
  when(term
    pin = nth(0 term~>pins)
    fig = car(pin~>figs)
    bb = fig~>bBox
    w = car(cadr(bb)) - car(car(bb))
    h = cadr(cadr(bb)) - cadr(car(bb))
    fig~>bBox = list(list(2.75 - w/2.0 3 - h/2.0) list(2.75 + w/2.0 3 + h/2.0))
  )
  lbl = car(setof(s cv~>shapes s~>objType == "label" && s~>theLabel == "SDO_CORE" && abs(car(s~>xy) - 2.8125) < 0.01 && abs(cadr(s~>xy) - 0.775) < 0.01))
  when(lbl dbDeleteObject(lbl))
  term = nth(45 cv~>terminals)
  when(term
    pin = nth(0 term~>pins)
    fig = car(pin~>figs)
    bb = fig~>bBox
    w = car(cadr(bb)) - car(car(bb))
    h = cadr(cadr(bb)) - cadr(car(bb))
    fig~>bBox = list(list(3.25 - w/2.0 3 - h/2.0) list(3.25 + w/2.0 3 + h/2.0))
  )
  lbl = car(setof(s cv~>shapes s~>objType == "label" && s~>theLabel == "SCK_CORE" && abs(car(s~>xy) - 3.0625) < 0.01 && abs(cadr(s~>xy) - 0.775) < 0.01))
  when(lbl dbDeleteObject(lbl))
  term = nth(47 cv~>terminals)
  when(term
    pin = nth(0 term~>pins)
    fig = car(pin~>figs)
    bb = fig~>bBox
    w = car(cadr(bb)) - car(car(bb))
    h = cadr(cadr(bb)) - cadr(car(bb))
    fig~>bBox = list(list(3.75 - w/2.0 3 - h/2.0) list(3.75 + w/2.0 3 + h/2.0))
  )
  lbl = car(setof(s cv~>shapes s~>objType == "label" && s~>theLabel == "SDI_CORE" && abs(car(s~>xy) - 3.3125) < 0.01 && abs(cadr(s~>xy) - 0.775) < 0.01))
  when(lbl dbDeleteObject(lbl))
  term = nth(49 cv~>terminals)
  when(term
    pin = nth(0 term~>pins)
    fig = car(pin~>figs)
    bb = fig~>bBox
    w = car(cadr(bb)) - car(car(bb))
    h = cadr(cadr(bb)) - cadr(car(bb))
    fig~>bBox = list(list(4.25 - w/2.0 3 - h/2.0) list(4.25 + w/2.0 3 + h/2.0))
  )
  lbl = car(setof(s cv~>shapes s~>objType == "label" && s~>theLabel == "SLP_CORE" && abs(car(s~>xy) - 3.5625) < 0.01 && abs(cadr(s~>xy) - 0.775) < 0.01))
  when(lbl dbDeleteObject(lbl))
  term = nth(55 cv~>terminals)
  when(term
    pin = nth(0 term~>pins)
    fig = car(pin~>figs)
    bb = fig~>bBox
    w = car(cadr(bb)) - car(car(bb))
    h = cadr(cadr(bb)) - cadr(car(bb))
    fig~>bBox = list(list(1.75 - w/2.0 -4 - h/2.0) list(1.75 + w/2.0 -4 + h/2.0))
  )
  lbl = car(setof(s cv~>shapes s~>objType == "label" && s~>theLabel == "VDDIB_CORE" && abs(car(s~>xy) - 1.5625) < 0.01 && abs(cadr(s~>xy) - -2.65) < 0.01))
  when(lbl dbDeleteObject(lbl))
  term = nth(60 cv~>terminals)
  when(term
    pin = nth(0 term~>pins)
    fig = car(pin~>figs)
    bb = fig~>bBox
    w = car(cadr(bb)) - car(car(bb))
    h = cadr(cadr(bb)) - cadr(car(bb))
    fig~>bBox = list(list(3.75 - w/2.0 -4 - h/2.0) list(3.75 + w/2.0 -4 + h/2.0))
  )
  lbl = car(setof(s cv~>shapes s~>objType == "label" && s~>theLabel == "VSSIB_CORE" && abs(car(s~>xy) - 2.1875) < 0.01 && abs(cadr(s~>xy) - -2.65) < 0.01))
  when(lbl dbDeleteObject(lbl))
  term = nth(62 cv~>terminals)
  when(term
    pin = nth(0 term~>pins)
    fig = car(pin~>figs)
    bb = fig~>bBox
    w = car(cadr(bb)) - car(car(bb))
    h = cadr(cadr(bb)) - cadr(car(bb))
    fig~>bBox = list(list(4.75 - w/2.0 -4 - h/2.0) list(4.75 + w/2.0 -4 + h/2.0))
  )
  lbl = car(setof(s cv~>shapes s~>objType == "label" && s~>theLabel == "VDD_CKB_CORE" && abs(car(s~>xy) - 2.5625) < 0.01 && abs(cadr(s~>xy) - -2.65) < 0.01))
  when(lbl dbDeleteObject(lbl))
  term = nth(64 cv~>terminals)
  when(term
    pin = nth(0 term~>pins)
    fig = car(pin~>figs)
    bb = fig~>bBox
    w = car(cadr(bb)) - car(car(bb))
    h = cadr(cadr(bb)) - cadr(car(bb))
    fig~>bBox = list(list(5.25 - w/2.0 -4 - h/2.0) list(5.25 + w/2.0 -4 + h/2.0))
  )
  lbl = car(setof(s cv~>shapes s~>objType == "label" && s~>theLabel == "GND_CKB_CORE" && abs(car(s~>xy) - 2.8125) < 0.01 && abs(cadr(s~>xy) - -2.65) < 0.01))
  when(lbl dbDeleteObject(lbl))
  dbSave(cv)
  printf("APPLY-LAYOUT: OK  pins=68  core=20")
  t
)
