// Design: LLM_Layout_Design/_tb_inv
simulator lang=spectre
global 0
include "/home/process/tsmc28n/PDK_mmWave/iPDK_CRN28HPC+ULL_v1.8_2p2a_20190531/models/spectre/toplevel.scs" section=TOP_TT

// LLM_Layout_Design/inv/schematic
subckt inv VDD VIN VOUT VSS
    M0 (VOUT VIN VSS VSS) nch_mac l=30n w=1u multi=1 nf=1 sd=100n
    M1 (VOUT VIN VDD VDD) pch_mac l=30n w=2u multi=1 nf=1 sd=100n
ends inv

// LLM_Layout_Design/_tb_inv/schematic
V1 (VDD 0) vsource dc=900.0m type=dc
V0 (VSS 0) vsource dc=0 type=dc
V2 (VIN 0) vsource dc=0 type=pulse val0=0 val1=900.0m period=1n width=500p rise=20p fall=20p
Cload (VOUT 0) capacitor c=10f
I3 (VDD VIN VOUT VSS) inv
simulatorOptions options reltol=1e-4 temp=27
tran tran stop=3n errpreset=conservative savetime=[600] flushtime=30
