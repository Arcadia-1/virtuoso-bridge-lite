// PLAYGROUND_LLM/rc_unit/schematic
subckt rc_unit IN OUT VSS
    C0 (OUT VSS) capacitor c=1e-12
    R0 (IN OUT) resistor r=1000
ends rc_unit

// PLAYGROUND_LLM/rc_cascade_2/schematic
subckt rc_cascade_2 VIN VOUT VSS
    X2 (MID VOUT VSS) rc_unit
    X1 (VIN MID VSS) rc_unit
ends rc_cascade_2

// PLAYGROUND_LLM/tb_rc_cascade/schematic
X_DUT (VIN VOUT VSS) rc_cascade_2
V1 (VIN VSS) vsource mag=1 type=sine
